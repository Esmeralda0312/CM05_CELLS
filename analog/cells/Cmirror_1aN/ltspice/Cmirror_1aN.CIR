* C:\Users\esmer\OneDrive\Documentos\Repositorio_Analogico\CM05_CELLS\analog\cells\Cmirror_1aN\ltspice\Cmirror_1aN_tb.asc
* Generated by LTspice 26.0.2 for Windows.
XX1 P1 P2_2 P2_4 P2_8 COM Cmirror_1aN

* block symbol definitions
.subckt Cmirror_1aN P1 P2_2 P2_4 P2_8 COM
MD1 COM COM COM COM CIDNMOS l=10u w=100u
MC1 P2_8 P1 COM COM CIDNMOS l=10u w=100u
MB1 P2_4 P1 COM COM CIDNMOS l=10u w=100u
MC2 P2_8 P1 COM COM CIDNMOS l=10u w=100u
MA1 P2_2 P1 COM COM CIDNMOS l=10u w=100u
MREF P1 P1 COM COM CIDNMOS l=10u w=100u
MC3 P2_8 P1 COM COM CIDNMOS l=10u w=100u
MB2 P2_4 P1 COM COM CIDNMOS l=10u w=100u
MC4 P2_8 P1 COM COM CIDNMOS l=10u w=100u
MD2 COM COM COM COM CIDNMOS l=10u w=100u
MD3 COM COM COM COM CIDNMOS l=10u w=100u
MC5 P2_8 P1 COM COM CIDNMOS l=10u w=100u
MB3 P2_4 P1 COM COM CIDNMOS l=10u w=100u
MC6 P2_8 P1 COM COM CIDNMOS l=10u w=100u
MDUM COM COM COM COM CIDNMOS l=10u w=100u
MA2 P2_2 P1 COM COM CIDNMOS l=10u w=100u
MC7 P2_8 P1 COM COM CIDNMOS l=10u w=100u
MB4 P2_4 P1 COM COM CIDNMOS l=10u w=100u
MC8 P2_8 P1 COM COM CIDNMOS l=10u w=100u
MD4 COM COM COM COM CIDNMOS l=10u w=100u
.ends Cmirror_1aN

.model NMOS NMOS
.model PMOS PMOS
.lib C:\Users\esmer\AppData\Local\LTspice\lib\cmp\standard.mos
.backanno
.end
