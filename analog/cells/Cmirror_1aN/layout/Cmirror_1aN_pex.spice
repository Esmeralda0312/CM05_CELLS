* SPICE3 file created from Cmirror_1aN.ext - technology: scmos

.global Vdd Gnd

.subckt Cmirror_1aN_p COM  P2_8  P2_4  P2_2  P1
M1000  P2_4.t0  P1.t10 COM.t1 COM.t1 CIDNMOS w=100u l=10u
+  ad=2.5n pd=0.25m as=1.25n ps=0.125m
M1001 COM.t1  P1.t4  P2_8.t3 COM.t1 CIDNMOS w=100u l=10u
+  ad=1.25n pd=0.125m as=2.5n ps=0.25m
M1002 COM.t1  P1.t9  P2_8.t0 COM.t1 CIDNMOS w=100u l=10u
+  ad=1.25n pd=0.125m as=2.5n ps=0.25m
M1003 COM.t8 COM.t6 COM.t1 COM.t1 CIDNMOS w=100u l=10u
+  ad=2.5n pd=0.25m as=0 ps=0
M1004  P2_8.t4  P1.t6 COM.t1 COM.t1 CIDNMOS w=100u l=10u
+  ad=2.5n pd=0.25m as=1.25n ps=0.125m
M1005  P2_8.t2  P1.t8 COM.t1 COM.t1 CIDNMOS w=100u l=10u
+  ad=2.5n pd=0.25m as=1.25n ps=0.125m
M1006 COM.t1  P1.t2  P2_8.t1 COM.t1 CIDNMOS w=100u l=10u
+  ad=1.25n pd=0.125m as=2.5n ps=0.25m
M1007 COM.t1 COM.t0 COM.t1 COM.t1 CIDNMOS w=100u l=10u
+  ad=2.5n pd=0.25m as=0 ps=0
M1008  P2_4.t2  P1.t3 COM.t1 COM.t1 CIDNMOS w=100u l=10u
+  ad=2.5n pd=0.25m as=1.25n ps=0.125m
M1009 COM.t1  P1.t14  P2_4 COM.t1 CIDNMOS w=100u l=10u
+  ad=1.25n pd=0.125m as=2.5n ps=0.25m
M1010 COM.t1  P1.t7  P2_4.t1 COM.t1 CIDNMOS w=100u l=10u
+  ad=1.25n pd=0.125m as=2.5n ps=0.25m
M1011  P2_2.t0  P1.t5 COM.t8 COM.t1 CIDNMOS w=100u l=10u
+  ad=2.5n pd=0.25m as=1.25n ps=0.125m
M1012  P2_8  P1.t15 COM.t1 COM.t1 CIDNMOS w=100u l=10u
+  ad=2.5n pd=0.25m as=1.25n ps=0.125m
M1013  P2_8  P1.t13 COM.t1 COM.t1 CIDNMOS w=100u l=10u
+  ad=2.5n pd=0.25m as=1.25n ps=0.125m
M1014 COM.t1  P1.t12  P2_2.t1 COM.t1 CIDNMOS w=100u l=10u
+  ad=1.25n pd=0.125m as=2.5n ps=0.25m
M1015 COM.t1 COM.t4 COM.t1 COM.t1 CIDNMOS w=100u l=10u
+  ad=2.5n pd=0.25m as=0 ps=0
M1016 COM.t1 COM.t9 COM.t1 COM.t1 CIDNMOS w=100u l=10u
+  ad=1.25n pd=0.125m as=0 ps=0
M1017 COM.t1  P1.t11  P2_8.t0 COM.t1 CIDNMOS w=100u l=10u
+  ad=1.25n pd=0.125m as=2.5n ps=0.25m
M1018 COM.t1 COM.t2 COM.t1 COM.t1 CIDNMOS w=100u l=10u
+  ad=1.25n pd=0.125m as=0 ps=0
M1019  P1.t1  P1.t0 COM.t1 COM.t1 CIDNMOS w=100u l=10u
+  ad=2.5n pd=0.25m as=1.25n ps=0.125m
R0  P2_2.n0  P2_2.t0 1.31148
R1  P2_2  P2_2.n0 1.17383
R2  P2_2.n0  P2_2.t1 1.05716
R3  P2_4  P2_4.t0 1.46768
R4  P2_4.t0  P2_4.t2 1.07264
R5  P2_4  P2_4.t1 1.07264
R6  P2_8.t0  P2_8.t3 1.75533
R7  P2_8  P2_8.t0 1.26768
R8  P2_8.t0  P2_8.t1 1.20764
R9  P2_8  P2_8.t4 1.20764
R10  P2_8  P2_8.t2 1.20764
R11  P1.t1  P1.t9 29250.5
R12  P1.t1  P1.t10 29250.5
R13  P1.t1  P1.t11 29250.5
R14  P1.t1  P1.t12 29250.5
R15  P1  P1.t13 29250.5
R16  P1  P1.t14 29250.5
R17  P1  P1.t15 29250.5
R18  P1.t1  P1.t2 29250.1
R19  P1.t1  P1.t3 29250.1
R20  P1.t1  P1.t4 29250.1
R21  P1  P1.t6 29250.1
R22  P1  P1.t7 29250.1
R23  P1  P1.t8 29250.1
R24  P1.t1  P1.t5 29250.1
R25  P1.t1  P1.t0 29250
R26  P1  P1.t1 2.45406
R27 COM.t1 COM.t6 34875
R28 COM.t1 COM.t2 33750
R29 COM.t1 COM.t0 33750
R30 COM.t1 COM.t4 33750
R31 COM.t1 COM.t9 33750
R32 COM.t1 COM.t8 1.58503
R33 COM COM.t1 0.0005
C0  P2_4  P2_2 40.8897f
C1  P2_2  P1 0.11952p
C2  P2_4  P1 0.13108p
C3  P2_2  P2_8 65.2089f
C4  P2_4  P2_8 80.0199f
C5  P1  P2_8 0.1579p
C6  P2_2 COM 24.74782f
C7  P2_4 COM 0.1058p
C8  P2_8 COM 0.12046p
C9  P1 COM 92.93668f
C10  P1.t1 COM 0.17593p
C11  P1.t9 COM 9.63313f
C12  P1.t2 COM 9.633f
C13  P1.t10 COM 9.63313f
C14  P1.t3 COM 9.633f
C15  P1.t11 COM 9.63313f
C16  P1.t4 COM 9.633f
C17  P1.t0 COM 9.63299f
C18  P1.t5 COM 9.633f
C19  P1.t12 COM 9.63313f
C20  P1.t13 COM 9.63313f
C21  P1.t6 COM 9.633f
C22  P1.t14 COM 9.63313f
C23  P1.t7 COM 9.633f
C24  P1.t15 COM 9.63313f
C25  P1.t8 COM 9.633f
C26  P2_8.t0 COM 0.11693p
C27  P2_8.t1 COM 17.3163f
C28  P2_8.t3 COM 17.3163f
C29  P2_8.t4 COM 17.3163f
C30  P2_8.t2 COM 17.3163f
C31  P2_4.t0 COM 0.10443p
C32  P2_4.t2 COM 21.551f
C33  P2_4.t1 COM 21.551f
C34  P2_2.t0 COM 49.4669f
C35  P2_2.t1 COM 28.7186f
C36  P2_2.n0 COM 0.12352p
.ends
