* SPICE3 file created from Cmirror_1aN.ext - technology: scmos

.global Vdd Gnd

.subckt Cmirror_1aN_p COM P1 P2_2  P2_4  P2_8
M1000 COM.t1 P1.t14  P2_4 COM.t1 CIDNMOS w=100u l=10u
+  ad=0.75n pd=0.115m as=1.5n ps=0.23m
M1001 COM.t1 COM.t5 COM.t1 COM.t1 CIDNMOS w=100u l=10u
+  ad=1.5n pd=0.23m as=0 ps=0
M1002 COM.t1 P1.t2  P2_8.t3 COM.t1 CIDNMOS w=100u l=10u
+  ad=0.75n pd=0.115m as=1.5n ps=0.23m
M1003  P2_8.t2 P1.t8 COM.t1 COM.t1 CIDNMOS w=100u l=10u
+  ad=1.5n pd=0.23m as=0.75n ps=0.115m
M1004 COM.t1 COM.t0 COM.t2 COM.t1 CIDNMOS w=100u l=10u
+  ad=1.5n pd=0.23m as=0 ps=0
M1005 COM.t1 P1.t9  P2_8.t0 COM.t1 CIDNMOS w=100u l=10u
+  ad=0.75n pd=0.115m as=1.5n ps=0.23m
M1006  P2_8.t2 P1.t15 COM.t2 COM.t1 CIDNMOS w=100u l=10u
+  ad=1.5n pd=0.23m as=0.75n ps=0.115m
M1007 COM.t1 COM.t9 COM.t1 COM.t1 CIDNMOS w=100u l=10u
+  ad=0.75n pd=0.115m as=0 ps=0
M1008  P2_4.t0 P1.t3 COM.t1 COM.t1 CIDNMOS w=100u l=10u
+  ad=1.5n pd=0.23m as=0.75n ps=0.115m
M1009 COM.t1 COM.t7 COM.t1 COM.t1 CIDNMOS w=100u l=10u
+  ad=1.5n pd=0.23m as=0 ps=0
M1010 COM.t1 P1.t4  P2_8.t0 COM.t1 CIDNMOS w=100u l=10u
+  ad=0.75n pd=0.115m as=1.5n ps=0.23m
M1011 COM.t1 COM.t3 COM.t1 COM.t1 CIDNMOS w=100u l=10u
+  ad=0.75n pd=0.115m as=0 ps=0
M1012 COM.t1 P1.t12 P2_2.t0 COM.t1 CIDNMOS w=100u l=10u
+  ad=0.75n pd=0.115m as=1.5n ps=0.23m
M1013  P2_4.t0 P1.t10 COM.t1 COM.t1 CIDNMOS w=100u l=10u
+  ad=1.5n pd=0.23m as=0.75n ps=0.115m
M1014 COM.t1 P1.t11  P2_8.t0 COM.t1 CIDNMOS w=100u l=10u
+  ad=0.75n pd=0.115m as=1.5n ps=0.23m
M1015 P2_2.t0 P1.t5 COM.t1 COM.t1 CIDNMOS w=100u l=10u
+  ad=1.5n pd=0.23m as=0.75n ps=0.115m
M1016  P2_8.t1 P1.t6 COM.t1 COM.t1 CIDNMOS w=100u l=10u
+  ad=1.5n pd=0.23m as=0.75n ps=0.115m
M1017 COM.t1 P1.t7  P2_4 COM.t1 CIDNMOS w=100u l=10u
+  ad=0.75n pd=0.115m as=1.5n ps=0.23m
M1018  P2_8.t0 P1.t13 COM.t1 COM.t1 CIDNMOS w=100u l=10u
+  ad=1.5n pd=0.23m as=0.75n ps=0.115m
M1019 P1.t1 P1.t0 COM.t1 COM.t1 CIDNMOS w=100u l=10u
+  ad=1.5n pd=0.23m as=0.75n ps=0.115m
R0 P2_2 P2_2.t0 1.57233
R1  P2_4  P2_4.t0 1.04101
R2  P2_8.t0  P2_8.t1 1.43482
R3  P2_8.t0  P2_8.t3 1.31482
R4  P2_8.t2  P2_8.t0 1.31482
R5  P2_8  P2_8.t3 0.0005
R6 P1.n7 P1.t15 60750
R7 P1.n6 P1.t14 60750
R8 P1.n5 P1.t13 60750
R9 P1.n4 P1.t12 60750
R10 P1.n2 P1.t11 60750
R11 P1.n1 P1.t10 60750
R12 P1.n0 P1.t9 60750
R13 P1.n7 P1.t8 30375
R14 P1.n6 P1.t7 30375
R15 P1.n5 P1.t6 30375
R16 P1.n3 P1.t1 30375
R17 P1.t1 P1.t0 30375
R18 P1.n3 P1.t5 30375
R19 P1.n2 P1.t4 30375
R20 P1.n1 P1.t3 30375
R21 P1.n0 P1.t2 30375
R22 P1.n7 P1.n6 21375
R23 P1.n3 P1.n2 21375
R24 P1.n1 P1.n0 21375
R25 P1.n5 P1 14625
R26 P1.n6 P1.n5 11250
R27 P1.n4 P1.n3 11250
R28 P1.n2 P1.n1 11250
R29 P1 P1.n4 6750
R30 P1 P1.n7 4500.09
R31 P1.n0 P1 3376.82
R32 COM.t1 COM.t0 31500
R33 COM.t1 COM.t5 31500
R34 COM.t1 COM.t7 31500
R35 COM.t1 COM.t3 31500
R36 COM.t2 COM.t1 0.574145
R37 COM.t9 COM.t1 31500
R38 COM COM.t1 0.0005
C0 P1  P2_8 67.3055f
C1 P2_2  P2_8 65.8317f
C2 P2_2 P1 14.3959f
C3  P2_4  P2_8 80.68279f
C4  P2_4 P1 26.1645f
C5  P2_4 P2_2 40.3644f
C6 P2_2 COM 68.2729f
C7  P2_4 COM 87.8565f
C8  P2_8 COM 16.2532f
C9 P1 COM 37.79221f
C10 P1.t15 COM 3.76019f
C11 P1.t8 COM 2.76485f
C12 P1.t14 COM 3.76019f
C13 P1.t7 COM 2.76485f
C14 P1.t13 COM 3.76019f
C15 P1.t6 COM 2.76485f
C16 P1.t12 COM 3.76019f
C17 P1.t0 COM 2.76485f
C18 P1.t1 COM 10.5433f
C19 P1.t5 COM 2.76485f
C20 P1.t11 COM 3.76019f
C21 P1.t4 COM 2.76485f
C22 P1.t10 COM 3.76019f
C23 P1.t3 COM 2.76485f
C24 P1.t9 COM 3.76019f
C25 P1.t2 COM 2.76485f
C26 P1.n0 COM 3.79861f
C27 P1.n1 COM 4.05511f
C28 P1.n2 COM 4.05511f
C29 P1.n3 COM 3.05976f
C30 P1.n4 COM 2.58052f
C31 P1.n5 COM 3.83392f
C32 P1.n6 COM 4.05511f
C33 P1.n7 COM 3.83394f
C34  P2_8.t3 COM 25.821f
C35  P2_8.t1 COM 13.9724f
C36  P2_8.t0 COM 0.14821p
C37  P2_8.t2 COM 25.821f
C38  P2_4.t0 COM 73.5948f
C39 P2_2.t0 COM 66.136f
.ends
