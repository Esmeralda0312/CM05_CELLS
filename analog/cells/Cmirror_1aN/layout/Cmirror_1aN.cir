* Extracted by KLayout (CIDESI_CM05, LNunT, CIDESI)

.SUBCKT Cmirror_1aN \\x20P2_8 P2_2 \\x20P2_4 P1 COM
M$1 COM P1 \\x20P2_8 COM CIDNMOS L=10U W=100U AS=1500P AD=750P PS=230U PD=115U
M$2 COM COM COM COM CIDNMOS L=10U W=100U AS=750P AD=1500P PS=115U PD=230U
M$3 COM P1 \\x20P2_8 COM CIDNMOS L=10U W=100U AS=1500P AD=750P PS=230U PD=115U
M$4 \\x20P2_4 P1 COM COM CIDNMOS L=10U W=100U AS=750P AD=1500P PS=115U PD=230U
M$5 COM P1 \\x20P2_4 COM CIDNMOS L=10U W=100U AS=1500P AD=750P PS=230U PD=115U
M$6 \\x20P2_8 P1 COM COM CIDNMOS L=10U W=100U AS=750P AD=1500P PS=115U PD=230U
M$7 COM COM COM COM CIDNMOS L=10U W=100U AS=1500P AD=750P PS=230U PD=115U
M$8 \\x20P2_8 P1 COM COM CIDNMOS L=10U W=100U AS=750P AD=1500P PS=115U PD=230U
M$9 COM P1 \\x20P2_4 COM CIDNMOS L=10U W=100U AS=1500P AD=750P PS=230U PD=115U
M$10 \\x20P2_8 P1 COM COM CIDNMOS L=10U W=100U AS=750P AD=1500P PS=115U PD=230U
M$11 COM COM COM COM CIDNMOS L=10U W=100U AS=1500P AD=750P PS=230U PD=115U
M$12 \\x20P2_8 P1 COM COM CIDNMOS L=10U W=100U AS=750P AD=1500P PS=115U PD=230U
M$13 COM COM COM COM CIDNMOS L=10U W=100U AS=1500P AD=750P PS=230U PD=115U
M$14 P2_2 P1 COM COM CIDNMOS L=10U W=100U AS=750P AD=1500P PS=115U PD=230U
M$15 COM P1 \\x20P2_8 COM CIDNMOS L=10U W=100U AS=1500P AD=750P PS=230U PD=115U
M$16 \\x20P2_4 P1 COM COM CIDNMOS L=10U W=100U AS=750P AD=1500P PS=115U PD=230U
M$17 COM P1 P2_2 COM CIDNMOS L=10U W=100U AS=1500P AD=750P PS=230U PD=115U
M$18 P1 P1 COM COM CIDNMOS L=10U W=100U AS=750P AD=1500P PS=115U PD=230U
M$19 COM P1 \\x20P2_8 COM CIDNMOS L=10U W=100U AS=1500P AD=750P PS=230U PD=115U
M$20 COM COM COM COM CIDNMOS L=10U W=100U AS=750P AD=1500P PS=115U PD=230U
.ENDS Cmirror_1aN
