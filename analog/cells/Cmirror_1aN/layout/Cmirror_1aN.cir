* Extracted by KLayout (CIDESI_CM05, LNunT, CIDESI)

.SUBCKT Cmirror_1aN \\x20P2_8 \\x20P2_4 \\x20P2_2 \\x20P1 COM
M$1 COM \\x20P1 \\x20P2_8 COM CIDNMOS L=10U W=100U AS=2500P AD=1250P PS=250U
+ PD=125U
M$2 COM COM COM COM CIDNMOS L=10U W=100U AS=1250P AD=2500P PS=125U PD=250U
M$3 COM \\x20P1 \\x20P2_8 COM CIDNMOS L=10U W=100U AS=2500P AD=1250P PS=250U
+ PD=125U
M$4 \\x20P2_4 \\x20P1 COM COM CIDNMOS L=10U W=100U AS=1250P AD=2500P PS=125U
+ PD=250U
M$5 COM \\x20P1 \\x20P2_2 COM CIDNMOS L=10U W=100U AS=2500P AD=1250P PS=250U
+ PD=125U
M$6 \\x20P1 \\x20P1 COM COM CIDNMOS L=10U W=100U AS=1250P AD=2500P PS=125U
+ PD=250U
M$7 COM COM COM COM CIDNMOS L=10U W=100U AS=2500P AD=1250P PS=250U PD=125U
M$8 \\x20P2_8 \\x20P1 COM COM CIDNMOS L=10U W=100U AS=1250P AD=2500P PS=125U
+ PD=250U
M$9 COM \\x20P1 \\x20P2_8 COM CIDNMOS L=10U W=100U AS=2500P AD=1250P PS=250U
+ PD=125U
M$10 \\x20P2_4 \\x20P1 COM COM CIDNMOS L=10U W=100U AS=1250P AD=2500P PS=125U
+ PD=250U
M$11 COM COM COM COM CIDNMOS L=10U W=100U AS=2500P AD=1250P PS=250U PD=125U
M$12 \\x20P2_8 \\x20P1 COM COM CIDNMOS L=10U W=100U AS=1250P AD=2500P PS=125U
+ PD=250U
M$13 COM \\x20P1 \\x20P2_4 COM CIDNMOS L=10U W=100U AS=2500P AD=1250P PS=250U
+ PD=125U
M$14 \\x20P2_8 \\x20P1 COM COM CIDNMOS L=10U W=100U AS=1250P AD=2500P PS=125U
+ PD=250U
M$15 COM COM COM COM CIDNMOS L=10U W=100U AS=2500P AD=1250P PS=250U PD=125U
M$16 \\x20P2_2 \\x20P1 COM COM CIDNMOS L=10U W=100U AS=1250P AD=2500P PS=125U
+ PD=250U
M$17 COM \\x20P1 \\x20P2_4 COM CIDNMOS L=10U W=100U AS=2500P AD=1250P PS=250U
+ PD=125U
M$18 \\x20P2_8 \\x20P1 COM COM CIDNMOS L=10U W=100U AS=1250P AD=2500P PS=125U
+ PD=250U
M$19 COM \\x20P1 \\x20P2_8 COM CIDNMOS L=10U W=100U AS=2500P AD=1250P PS=250U
+ PD=125U
M$20 COM COM COM COM CIDNMOS L=10U W=100U AS=1250P AD=2500P PS=125U PD=250U
.ENDS Cmirror_1aN
