* Extracted by KLayout (CIDESI_CM05, LNunT, CIDESI)

.SUBCKT Cmirror_1aN \\x20P2_8 P2_2 \\x20P2_4 P1 COM
X$1 COM GuardRing$1
M$1 COM P1 \\x20P2_8 COM CIDNMOS L=10U W=100U AS=1500P AD=750P PS=230U PD=115U
M$2 COM COM COM COM CIDNMOS L=10U W=100U AS=750P AD=1500P PS=115U PD=230U
M$3 COM P1 \\x20P2_8 COM CIDNMOS L=10U W=100U AS=1500P AD=750P PS=230U PD=115U
M$4 \\x20P2_4 P1 COM COM CIDNMOS L=10U W=100U AS=750P AD=1500P PS=115U PD=230U
M$5 COM P1 \\x20P2_4 COM CIDNMOS L=10U W=100U AS=1500P AD=750P PS=230U PD=115U
M$6 \\x20P2_8 P1 COM COM CIDNMOS L=10U W=100U AS=750P AD=1500P PS=115U PD=230U
M$7 COM COM COM COM CIDNMOS L=10U W=100U AS=1500P AD=750P PS=230U PD=115U
M$8 \\x20P2_8 P1 COM COM CIDNMOS L=10U W=100U AS=750P AD=1500P PS=115U PD=230U
M$9 COM P1 \\x20P2_4 COM CIDNMOS L=10U W=100U AS=1500P AD=750P PS=230U PD=115U
M$10 \\x20P2_8 P1 COM COM CIDNMOS L=10U W=100U AS=750P AD=1500P PS=115U PD=230U
M$11 COM COM COM COM CIDNMOS L=10U W=100U AS=1500P AD=750P PS=230U PD=115U
M$12 \\x20P2_8 P1 COM COM CIDNMOS L=10U W=100U AS=750P AD=1500P PS=115U PD=230U
M$13 COM COM COM COM CIDNMOS L=10U W=100U AS=1500P AD=750P PS=230U PD=115U
M$14 P2_2 P1 COM COM CIDNMOS L=10U W=100U AS=750P AD=1500P PS=115U PD=230U
M$15 COM P1 \\x20P2_8 COM CIDNMOS L=10U W=100U AS=1500P AD=750P PS=230U PD=115U
M$16 \\x20P2_4 P1 COM COM CIDNMOS L=10U W=100U AS=750P AD=1500P PS=115U PD=230U
M$17 COM P1 P2_2 COM CIDNMOS L=10U W=100U AS=1500P AD=750P PS=230U PD=115U
M$18 P1 P1 COM COM CIDNMOS L=10U W=100U AS=750P AD=1500P PS=115U PD=230U
M$19 COM P1 \\x20P2_8 COM CIDNMOS L=10U W=100U AS=1500P AD=750P PS=230U PD=115U
M$20 COM COM COM COM CIDNMOS L=10U W=100U AS=750P AD=1500P PS=115U PD=230U
C$21 \\x20P2_8 COM 7.39957124706e-15 ; C_PAR_M1M2
C$22 \\x20P2_8 \\x20P2_4 7.39957124706e-15 ; C_PAR_M1M2
C$23 \\x20P2_8 P1 7.09125577844e-15 ; C_PAR_M1M2
C$24 \\x20P2_4 COM 7.39957124706e-15 ; C_PAR_M1M2
C$25 \\x20P2_4 \\x20P2_8 7.39957124706e-15 ; C_PAR_M1M2
C$26 \\x20P2_4 P2_2 7.39957124706e-15 ; C_PAR_M1M2
C$27 \\x20P2_4 \\x20P2_8 7.39957124706e-15 ; C_PAR_M1M2
C$28 P2_2 COM 7.39957124706e-15 ; C_PAR_M1M2
C$29 P1 \\x20P2_8 7.39957124706e-15 ; C_PAR_M1M2
C$30 \\x20P2_4 \\x20P2_8 7.39957124706e-15 ; C_PAR_M1M2
C$31 P1 \\x20P2_4 7.39957124706e-15 ; C_PAR_M1M2
C$32 P1 P2_2 7.39957124706e-15 ; C_PAR_M1M2
C$33 P1 \\x20P2_8 7.39957124706e-15 ; C_PAR_M1M2
C$34 \\x20P2_8 \\x20P2_4 7.39957124706e-15 ; C_PAR_M1M2
C$35 P1 \\x20P2_8 7.39957124706e-15 ; C_PAR_M1M2
C$36 P1 \\x20P2_8 7.39957124706e-15 ; C_PAR_M1M2
C$37 P2_2 \\x20P2_8 7.39957124706e-15 ; C_PAR_M1M2
C$38 P2_2 \\x20P2_4 7.39957124706e-15 ; C_PAR_M1M2
C$39 \\x20P2_4 \\x20P2_8 7.39957124706e-15 ; C_PAR_M1M2
C$40 P2_2 \\x20P2_8 7.39957124706e-15 ; C_PAR_M1M2
C$41 P1 \\x20P2_4 7.39957124706e-15 ; C_PAR_M1M2
C$42 \\x20P2_8 P2_2 7.39957124706e-15 ; C_PAR_M1M2
C$43 P1 COM 7.39957124706e-15 ; C_PAR_M1M2
C$44 P2_2 \\x20P2_4 7.39957124706e-15 ; C_PAR_M1M2
C$45 P2_2 \\x20P2_8 7.39957124706e-15 ; C_PAR_M1M2
C$46 P2_2 \\x20P2_8 7.39957124706e-15 ; C_PAR_M1M2
C$47 COM COM 2.87761104052e-15 ; C_M1_SUB
C$48 COM COM 2.87761104052e-15 ; C_M1_SUB
C$49 COM COM 2.87761104052e-15 ; C_M1_SUB
C$50 COM COM 2.87761104052e-15 ; C_M1_SUB
C$51 COM COM 2.87761104052e-15 ; C_M1_SUB
C$52 COM COM 4.31641656079e-15 ; C_M1_SUB
C$53 COM COM 1.29492496824e-14 ; C_M1_SUB
C$54 \\x20P2_8 COM 2.87761104052e-15 ; C_M1_SUB
C$55 \\x20P2_4 COM 2.87761104052e-15 ; C_M1_SUB
C$56 COM COM 1.29492496824e-14 ; C_M1_SUB
C$57 \\x20P2_8 COM 2.87761104052e-15 ; C_M1_SUB
C$58 COM COM 4.31641656079e-15 ; C_M1_SUB
C$59 COM COM 1.29492496824e-14 ; C_M1_SUB
C$60 P2_2 COM 2.87761104052e-15 ; C_M1_SUB
C$61 \\x20P2_8 COM 2.87761104052e-15 ; C_M1_SUB
C$62 COM COM 1.29492496824e-14 ; C_M1_SUB
C$63 \\x20P2_4 COM 2.87761104052e-15 ; C_M1_SUB
C$64 \\x20P2_8 COM 2.87761104052e-15 ; C_M1_SUB
C$65 COM COM 1.29492496824e-14 ; C_M1_SUB
C$66 COM COM 4.31641656079e-15 ; C_M1_SUB
C$67 COM COM 2.87761104052e-15 ; C_M1_SUB
C$68 COM COM 2.87761104052e-15 ; C_M1_SUB
C$69 COM COM 2.87761104052e-15 ; C_M1_SUB
C$70 COM COM 2.87761104052e-15 ; C_M1_SUB
C$71 COM COM 2.87761104052e-15 ; C_M1_SUB
C$72 COM COM 2.87761104052e-15 ; C_M1_SUB
C$73 COM COM 2.87761104052e-15 ; C_M1_SUB
C$74 \\x20P2_8 COM 1.00716386418e-14 ; C_M1_SUB
C$75 \\x20P2_4 COM 1.00716386418e-14 ; C_M1_SUB
C$76 \\x20P2_8 COM 1.00716386418e-14 ; C_M1_SUB
C$77 P2_2 COM 1.00716386418e-14 ; C_M1_SUB
C$78 \\x20P2_8 COM 1.00716386418e-14 ; C_M1_SUB
C$79 \\x20P2_4 COM 1.00716386418e-14 ; C_M1_SUB
C$80 \\x20P2_8 COM 1.00716386418e-14 ; C_M1_SUB
C$81 P1 COM 5.75522208105e-15 ; C_M1_SUB
C$82 P1 COM 5.75522208105e-15 ; C_M1_SUB
C$83 P2_2 COM 7.19402760131e-15 ; C_M1_SUB
C$84 P2_2 COM 1.43880552026e-14 ; C_M1_SUB
C$85 COM COM 2.87761104052e-15 ; C_M1_SUB
C$86 COM COM 2.87761104052e-15 ; C_M1_SUB
C$87 \\x20P2_8 COM 4.74805821687e-14 ; C_M1_SUB
C$88 \\x20P2_4 COM 4.74805821687e-14 ; C_M1_SUB
C$89 COM COM 2.87761104052e-15 ; C_M1_SUB
C$90 \\x20P2_8 COM 4.74805821687e-14 ; C_M1_SUB
C$91 P2_2 COM 4.31641656079e-14 ; C_M1_SUB
C$92 COM COM 2.87761104052e-15 ; C_M1_SUB
C$93 P1 COM 1.43880552026e-14 ; C_M1_SUB
C$94 \\x20P2_8 COM 4.74805821687e-14 ; C_M1_SUB
C$95 COM COM 2.87761104052e-15 ; C_M1_SUB
C$96 \\x20P2_4 COM 4.74805821687e-14 ; C_M1_SUB
C$97 \\x20P2_8 COM 4.74805821687e-14 ; C_M1_SUB
C$98 COM COM 2.87761104052e-15 ; C_M1_SUB
C$99 COM COM 6.47462484118e-14 ; C_M1_SUB
C$100 \\x20P2_8 COM 2.87761104052e-15 ; C_M1_SUB
C$101 \\x20P2_4 COM 2.87761104052e-15 ; C_M1_SUB
C$102 \\x20P2_8 COM 2.87761104052e-15 ; C_M1_SUB
C$103 P2_2 COM 2.87761104052e-15 ; C_M1_SUB
C$104 P1 COM 2.87761104052e-15 ; C_M1_SUB
C$105 \\x20P2_8 COM 2.87761104052e-15 ; C_M1_SUB
C$106 \\x20P2_4 COM 2.87761104052e-15 ; C_M1_SUB
C$107 \\x20P2_8 COM 2.87761104052e-15 ; C_M1_SUB
C$108 COM COM 4.31641656079e-15 ; C_M1_SUB
C$109 COM COM 4.31641656079e-15 ; C_M1_SUB
C$110 COM COM 2.87761104052e-15 ; C_M1_SUB
C$111 COM COM 1.29492496824e-14 ; C_M1_SUB
C$112 COM COM 1.29492496824e-14 ; C_M1_SUB
C$113 COM COM 1.29492496824e-14 ; C_M1_SUB
C$114 COM COM 1.29492496824e-14 ; C_M1_SUB
C$115 COM COM 1.29492496824e-14 ; C_M1_SUB
C$116 COM COM 2.87761104052e-15 ; C_M1_SUB
C$117 COM COM 2.87761104052e-15 ; C_M1_SUB
C$118 COM COM 2.87761104052e-15 ; C_M1_SUB
C$119 P1 COM 1.39239243896e-16 ; C_M2_SUB
C$120 P1 COM 6.96196219482e-16 ; C_M2_SUB
C$121 P1 COM 1.39239243896e-16 ; C_M2_SUB
C$122 P1 COM 8.35435463378e-16 ; C_M2_SUB
C$123 P1 COM 1.39239243896e-16 ; C_M2_SUB
C$124 P1 COM 2.78478487793e-15 ; C_M2_SUB
C$125 P1 COM 1.39239243896e-16 ; C_M2_SUB
C$126 P1 COM 6.96196219482e-16 ; C_M2_SUB
C$127 P1 COM 1.39239243896e-16 ; C_M2_SUB
C$128 P1 COM 8.35435463378e-16 ; C_M2_SUB
C$129 P1 COM 1.39239243896e-16 ; C_M2_SUB
C$130 P1 COM 6.96196219482e-16 ; C_M2_SUB
C$131 P1 COM 1.39239243896e-16 ; C_M2_SUB
C$132 P1 COM 9.46826858495e-15 ; C_M2_SUB
C$133 P1 COM 1.39239243896e-16 ; C_M2_SUB
C$134 P1 COM 6.96196219482e-16 ; C_M2_SUB
C$135 P1 COM 1.39239243896e-16 ; C_M2_SUB
C$136 P1 COM 8.35435463378e-16 ; C_M2_SUB
C$137 P1 COM 1.39239243896e-16 ; C_M2_SUB
C$138 P1 COM 1.39239243896e-15 ; C_M2_SUB
C$139 P1 COM 8.35435463378e-16 ; C_M2_SUB
C$140 P1 COM 1.39239243896e-16 ; C_M2_SUB
C$141 P1 COM 6.96196219482e-16 ; C_M2_SUB
C$142 P1 COM 1.39239243896e-16 ; C_M2_SUB
C$143 P1 COM 8.35435463378e-16 ; C_M2_SUB
C$144 P1 COM 1.39239243896e-16 ; C_M2_SUB
C$145 P1 COM 6.96196219482e-16 ; C_M2_SUB
C$146 P1 COM 1.39239243896e-16 ; C_M2_SUB
C$147 P1 COM 4.73413429248e-15 ; C_M2_SUB
C$148 P1 COM 2.50630639013e-15 ; C_M2_SUB
C$149 P2_2 COM 1.39239243896e-16 ; C_M2_SUB
C$150 P2_2 COM 8.35435463378e-16 ; C_M2_SUB
C$151 P2_2 COM 1.39239243896e-16 ; C_M2_SUB
C$152 P2_2 COM 1.50378383408e-14 ; C_M2_SUB
C$153 P2_2 COM 8.35435463378e-16 ; C_M2_SUB
C$154 P2_2 COM 4.17717731689e-15 ; C_M2_SUB
C$155 P2_2 COM 8.35435463378e-16 ; C_M2_SUB
C$156 P2_2 COM 5.01261278027e-15 ; C_M2_SUB
C$157 P2_2 COM 8.35435463378e-16 ; C_M2_SUB
C$158 P2_2 COM 4.17717731689e-15 ; C_M2_SUB
C$159 P2_2 COM 1.39239243896e-16 ; C_M2_SUB
C$160 P2_2 COM 8.35435463378e-16 ; C_M2_SUB
C$161 P2_2 COM 1.39239243896e-16 ; C_M2_SUB
C$162 P2_2 COM 4.17717731689e-15 ; C_M2_SUB
C$163 P2_2 COM 8.35435463378e-16 ; C_M2_SUB
C$164 P2_2 COM 5.01261278027e-15 ; C_M2_SUB
C$165 P2_2 COM 8.35435463378e-16 ; C_M2_SUB
C$166 P2_2 COM 4.17717731689e-15 ; C_M2_SUB
C$167 P2_2 COM 8.35435463378e-16 ; C_M2_SUB
C$168 P2_2 COM 9.18979009716e-15 ; C_M2_SUB
C$169 P2_2 COM 2.50630639013e-15 ; C_M2_SUB
C$170 \\x20P2_4 COM 1.50378383408e-14 ; C_M2_SUB
C$171 \\x20P2_4 COM 8.35435463378e-16 ; C_M2_SUB
C$172 \\x20P2_4 COM 4.17717731689e-15 ; C_M2_SUB
C$173 \\x20P2_4 COM 8.35435463378e-16 ; C_M2_SUB
C$174 \\x20P2_4 COM 5.01261278027e-15 ; C_M2_SUB
C$175 \\x20P2_4 COM 8.35435463378e-16 ; C_M2_SUB
C$176 \\x20P2_4 COM 4.17717731689e-15 ; C_M2_SUB
C$177 \\x20P2_4 COM 8.35435463378e-16 ; C_M2_SUB
C$178 \\x20P2_4 COM 5.01261278027e-15 ; C_M2_SUB
C$179 \\x20P2_4 COM 8.35435463378e-15 ; C_M2_SUB
C$180 \\x20P2_4 COM 8.35435463378e-16 ; C_M2_SUB
C$181 \\x20P2_4 COM 5.01261278027e-15 ; C_M2_SUB
C$182 \\x20P2_4 COM 8.35435463378e-16 ; C_M2_SUB
C$183 \\x20P2_4 COM 4.17717731689e-15 ; C_M2_SUB
C$184 \\x20P2_4 COM 8.35435463378e-16 ; C_M2_SUB
C$185 \\x20P2_4 COM 9.18979009716e-15 ; C_M2_SUB
C$186 \\x20P2_4 COM 2.50630639013e-15 ; C_M2_SUB
C$187 \\x20P2_8 COM 1.50378383408e-14 ; C_M2_SUB
C$188 \\x20P2_8 COM 8.35435463378e-16 ; C_M2_SUB
C$189 \\x20P2_8 COM 4.17717731689e-15 ; C_M2_SUB
C$190 \\x20P2_8 COM 8.35435463378e-16 ; C_M2_SUB
C$191 \\x20P2_8 COM 5.01261278027e-15 ; C_M2_SUB
C$192 \\x20P2_8 COM 8.35435463378e-16 ; C_M2_SUB
C$193 \\x20P2_8 COM 4.17717731689e-15 ; C_M2_SUB
C$194 \\x20P2_8 COM 8.35435463378e-16 ; C_M2_SUB
C$195 \\x20P2_8 COM 5.01261278027e-15 ; C_M2_SUB
C$196 \\x20P2_8 COM 6.26576597534e-15 ; C_M2_SUB
C$197 \\x20P2_8 COM 8.35435463378e-16 ; C_M2_SUB
C$198 \\x20P2_8 COM 5.01261278027e-15 ; C_M2_SUB
C$199 \\x20P2_8 COM 8.35435463378e-16 ; C_M2_SUB
C$200 \\x20P2_8 COM 4.17717731689e-15 ; C_M2_SUB
C$201 \\x20P2_8 COM 8.35435463378e-16 ; C_M2_SUB
C$202 \\x20P2_8 COM 9.18979009716e-15 ; C_M2_SUB
C$203 \\x20P2_8 COM 2.50630639013e-15 ; C_M2_SUB
C$204 COM COM 2.37402910843e-14 ; C_PO_SUB
C$205 P1 COM 8.63283312158e-15 ; C_PO_SUB
C$206 P1 COM 8.63283312158e-15 ; C_PO_SUB
C$207 P1 COM 8.63283312158e-15 ; C_PO_SUB
C$208 COM COM 2.37402910843e-14 ; C_PO_SUB
C$209 P1 COM 8.63283312158e-15 ; C_PO_SUB
C$210 P1 COM 8.63283312158e-15 ; C_PO_SUB
C$211 P1 COM 8.63283312158e-15 ; C_PO_SUB
C$212 P1 COM 8.63283312158e-15 ; C_PO_SUB
C$213 COM COM 2.37402910843e-14 ; C_PO_SUB
C$214 COM COM 8.63283312158e-15 ; C_PO_SUB
C$215 COM COM 8.63283312158e-15 ; C_PO_SUB
C$216 COM COM 8.63283312158e-15 ; C_PO_SUB
C$217 COM COM 8.63283312158e-15 ; C_PO_SUB
C$218 P1 COM 9.38820601971e-13 ; C_PO_SUB
C$219 COM COM 8.63283312158e-15 ; C_PO_SUB
C$220 P1 COM 8.63283312158e-15 ; C_PO_SUB
C$221 P1 COM 8.63283312158e-15 ; C_PO_SUB
C$222 P1 COM 8.63283312158e-15 ; C_PO_SUB
C$223 P1 COM 8.63283312158e-15 ; C_PO_SUB
C$224 P1 COM 8.63283312158e-15 ; C_PO_SUB
C$225 P1 COM 8.63283312158e-15 ; C_PO_SUB
C$226 P1 COM 8.63283312158e-15 ; C_PO_SUB
C$227 P1 COM 8.63283312158e-15 ; C_PO_SUB
C$228 COM COM 2.37402910843e-14 ; C_PO_SUB
C$229 COM COM 2.37402910843e-14 ; C_PO_SUB
.ENDS Cmirror_1aN

.SUBCKT GuardRing$1 \$1
.ENDS GuardRing$1
