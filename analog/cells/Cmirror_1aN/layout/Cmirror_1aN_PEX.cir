* Extracted by KLayout (CIDESI_CM05, LNunT, CIDESI)

.SUBCKT Cmirror_1aN \\x20P2_8 \\x20P2_4 \\x20P2_2 \\x20P1 COM
X$1 COM COM GuardRing$1
M$1 COM \\x20P1 \\x20P2_8 COM CIDNMOS L=10U W=100U AS=2500P AD=1250P PS=250U
+ PD=125U
M$2 COM COM COM COM CIDNMOS L=10U W=100U AS=1250P AD=2500P PS=125U PD=250U
M$3 COM \\x20P1 \\x20P2_8 COM CIDNMOS L=10U W=100U AS=2500P AD=1250P PS=250U
+ PD=125U
M$4 \\x20P2_4 \\x20P1 COM COM CIDNMOS L=10U W=100U AS=1250P AD=2500P PS=125U
+ PD=250U
M$5 COM \\x20P1 \\x20P2_2 COM CIDNMOS L=10U W=100U AS=2500P AD=1250P PS=250U
+ PD=125U
M$6 \\x20P1 \\x20P1 COM COM CIDNMOS L=10U W=100U AS=1250P AD=2500P PS=125U
+ PD=250U
M$7 COM COM COM COM CIDNMOS L=10U W=100U AS=2500P AD=1250P PS=250U PD=125U
M$8 \\x20P2_8 \\x20P1 COM COM CIDNMOS L=10U W=100U AS=1250P AD=2500P PS=125U
+ PD=250U
M$9 COM \\x20P1 \\x20P2_8 COM CIDNMOS L=10U W=100U AS=2500P AD=1250P PS=250U
+ PD=125U
M$10 \\x20P2_4 \\x20P1 COM COM CIDNMOS L=10U W=100U AS=1250P AD=2500P PS=125U
+ PD=250U
M$11 COM COM COM COM CIDNMOS L=10U W=100U AS=2500P AD=1250P PS=250U PD=125U
M$12 \\x20P2_8 \\x20P1 COM COM CIDNMOS L=10U W=100U AS=1250P AD=2500P PS=125U
+ PD=250U
M$13 COM \\x20P1 \\x20P2_4 COM CIDNMOS L=10U W=100U AS=2500P AD=1250P PS=250U
+ PD=125U
M$14 \\x20P2_8 \\x20P1 COM COM CIDNMOS L=10U W=100U AS=1250P AD=2500P PS=125U
+ PD=250U
M$15 COM COM COM COM CIDNMOS L=10U W=100U AS=2500P AD=1250P PS=250U PD=125U
M$16 \\x20P2_2 \\x20P1 COM COM CIDNMOS L=10U W=100U AS=1250P AD=2500P PS=125U
+ PD=250U
M$17 COM \\x20P1 \\x20P2_4 COM CIDNMOS L=10U W=100U AS=2500P AD=1250P PS=250U
+ PD=125U
M$18 \\x20P2_8 \\x20P1 COM COM CIDNMOS L=10U W=100U AS=1250P AD=2500P PS=125U
+ PD=250U
M$19 COM \\x20P1 \\x20P2_8 COM CIDNMOS L=10U W=100U AS=2500P AD=1250P PS=250U
+ PD=125U
M$20 COM COM COM COM CIDNMOS L=10U W=100U AS=1250P AD=2500P PS=125U PD=250U
C$21 \\x20P2_8 \\x20P1 7.39957124706e-15 ; C_PAR_M1M2
C$22 \\x20P2_8 \\x20P2_4 7.39957124706e-15 ; C_PAR_M1M2
C$23 \\x20P2_8 \\x20P1 7.39957124706e-15 ; C_PAR_M1M2
C$24 \\x20P2_8 \\x20P2_2 7.39957124706e-15 ; C_PAR_M1M2
C$25 \\x20P2_8 \\x20P1 7.39957124706e-15 ; C_PAR_M1M2
C$26 \\x20P2_8 \\x20P1 7.39957124706e-15 ; C_PAR_M1M2
C$27 \\x20P2_4 \\x20P1 7.39957124706e-15 ; C_PAR_M1M2
C$28 \\x20P2_4 \\x20P2_8 7.39957124706e-15 ; C_PAR_M1M2
C$29 \\x20P2_4 \\x20P1 7.39957124706e-15 ; C_PAR_M1M2
C$30 \\x20P2_8 \\x20P1 7.39957124706e-15 ; C_PAR_M1M2
C$31 \\x20P2_4 \\x20P1 7.39957124706e-15 ; C_PAR_M1M2
C$32 \\x20P2_4 \\x20P2_8 7.39957124706e-15 ; C_PAR_M1M2
C$33 \\x20P2_2 \\x20P2_8 7.39957124706e-15 ; C_PAR_M1M2
C$34 \\x20P2_2 \\x20P1 7.39957124706e-15 ; C_PAR_M1M2
C$35 \\x20P2_8 \\x20P1 7.39957124706e-15 ; C_PAR_M1M2
C$36 \\x20P2_2 \\x20P2_8 7.39957124706e-15 ; C_PAR_M1M2
C$37 \\x20P1 \\x20P2_4 7.39957124706e-15 ; C_PAR_M1M2
C$38 \\x20P1 \\x20P2_8 7.39957124706e-15 ; C_PAR_M1M2
C$39 \\x20P2_2 \\x20P2_4 7.39957124706e-15 ; C_PAR_M1M2
C$40 \\x20P2_4 \\x20P1 7.39957124706e-15 ; C_PAR_M1M2
C$41 \\x20P2_4 \\x20P1 7.39957124706e-15 ; C_PAR_M1M2
C$42 \\x20P1 \\x20P2_2 7.39957124706e-15 ; C_PAR_M1M2
C$43 \\x20P1 \\x20P2_8 7.39957124706e-15 ; C_PAR_M1M2
C$44 \\x20P2_4 \\x20P1 7.39957124706e-15 ; C_PAR_M1M2
C$45 \\x20P2_4 \\x20P1 7.39957124706e-15 ; C_PAR_M1M2
C$46 \\x20P2_8 \\x20P1 7.39957124706e-15 ; C_PAR_M1M2
C$47 \\x20P1 \\x20P2_4 7.39957124706e-15 ; C_PAR_M1M2
C$48 \\x20P2_2 \\x20P1 7.39957124706e-15 ; C_PAR_M1M2
C$49 \\x20P2_4 \\x20P1 7.39957124706e-15 ; C_PAR_M1M2
C$50 \\x20P1 \\x20P2_8 7.39957124706e-15 ; C_PAR_M1M2
C$51 \\x20P2_2 \\x20P2_8 7.39957124706e-15 ; C_PAR_M1M2
C$52 \\x20P2_2 \\x20P1 7.39957124706e-15 ; C_PAR_M1M2
C$53 \\x20P2_2 \\x20P1 7.39957124706e-15 ; C_PAR_M1M2
C$54 \\x20P1 \\x20P2_8 7.39957124706e-15 ; C_PAR_M1M2
C$55 \\x20P2_2 \\x20P2_8 7.39957124706e-15 ; C_PAR_M1M2
C$56 \\x20P2_2 \\x20P1 7.39957124706e-15 ; C_PAR_M1M2
C$57 \\x20P2_2 \\x20P2_4 7.39957124706e-15 ; C_PAR_M1M2
C$58 \\x20P2_8 \\x20P2_4 7.39957124706e-15 ; C_PAR_M1M2
C$59 \\x20P2_2 \\x20P1 7.39957124706e-15 ; C_PAR_M1M2
C$60 \\x20P2_2 \\x20P1 7.39957124706e-15 ; C_PAR_M1M2
C$61 \\x20P2_2 \\x20P1 7.39957124706e-15 ; C_PAR_M1M2
C$62 \\x20P2_4 \\x20P2_8 7.39957124706e-15 ; C_PAR_M1M2
C$63 \\x20P2_8 \\x20P1 7.39957124706e-15 ; C_PAR_M1M2
C$64 \\x20P2_4 \\x20P2_8 7.39957124706e-15 ; C_PAR_M1M2
C$65 \\x20P2_4 \\x20P2_2 7.39957124706e-15 ; C_PAR_M1M2
C$66 COM COM 8.63283312158e-15 ; C_M1_SUB
C$67 COM COM 1.00716386418e-14 ; C_M1_SUB
C$68 COM COM 1.00716386418e-14 ; C_M1_SUB
C$69 COM COM 4.31641656079e-15 ; C_M1_SUB
C$70 COM COM 2.01432772837e-14 ; C_M1_SUB
C$71 \\x20P2_8 COM 2.87761104052e-15 ; C_M1_SUB
C$72 \\x20P2_4 COM 2.87761104052e-15 ; C_M1_SUB
C$73 COM COM 2.01432772837e-14 ; C_M1_SUB
C$74 \\x20P2_8 COM 2.87761104052e-15 ; C_M1_SUB
C$75 COM COM 5.75522208105e-15 ; C_M1_SUB
C$76 COM COM 2.01432772837e-14 ; C_M1_SUB
C$77 \\x20P2_2 COM 2.87761104052e-15 ; C_M1_SUB
C$78 \\x20P2_8 COM 2.87761104052e-15 ; C_M1_SUB
C$79 COM COM 2.01432772837e-14 ; C_M1_SUB
C$80 \\x20P2_4 COM 2.87761104052e-15 ; C_M1_SUB
C$81 \\x20P2_8 COM 2.87761104052e-15 ; C_M1_SUB
C$82 COM COM 2.01432772837e-14 ; C_M1_SUB
C$83 COM COM 4.31641656079e-15 ; C_M1_SUB
C$84 COM COM 2.87761104052e-15 ; C_M1_SUB
C$85 COM COM 2.87761104052e-15 ; C_M1_SUB
C$86 COM COM 2.87761104052e-15 ; C_M1_SUB
C$87 COM COM 2.87761104052e-15 ; C_M1_SUB
C$88 COM COM 2.87761104052e-15 ; C_M1_SUB
C$89 COM COM 2.87761104052e-15 ; C_M1_SUB
C$90 COM COM 2.87761104052e-15 ; C_M1_SUB
C$91 COM COM 2.87761104052e-15 ; C_M1_SUB
C$92 \\x20P2_2 COM 3.16537214458e-14 ; C_M1_SUB
C$93 \\x20P1 COM 4.60417766484e-14 ; C_M1_SUB
C$94 \\x20P1 COM 4.60417766484e-14 ; C_M1_SUB
C$95 \\x20P1 COM 4.60417766484e-14 ; C_M1_SUB
C$96 \\x20P1 COM 4.60417766484e-14 ; C_M1_SUB
C$97 \\x20P1 COM 4.60417766484e-14 ; C_M1_SUB
C$98 \\x20P1 COM 4.60417766484e-14 ; C_M1_SUB
C$99 \\x20P1 COM 4.60417766484e-14 ; C_M1_SUB
C$100 COM COM 2.87761104052e-15 ; C_M1_SUB
C$101 COM COM 2.87761104052e-15 ; C_M1_SUB
C$102 \\x20P2_8 COM 6.90626649726e-14 ; C_M1_SUB
C$103 \\x20P2_4 COM 6.90626649726e-14 ; C_M1_SUB
C$104 COM COM 2.87761104052e-15 ; C_M1_SUB
C$105 \\x20P2_8 COM 6.90626649726e-14 ; C_M1_SUB
C$106 \\x20P2_2 COM 4.46029711281e-14 ; C_M1_SUB
C$107 COM COM 2.87761104052e-15 ; C_M1_SUB
C$108 \\x20P1 COM 6.18686373713e-14 ; C_M1_SUB
C$109 \\x20P2_8 COM 6.90626649726e-14 ; C_M1_SUB
C$110 COM COM 2.87761104052e-15 ; C_M1_SUB
C$111 \\x20P2_4 COM 6.90626649726e-14 ; C_M1_SUB
C$112 \\x20P2_8 COM 6.90626649726e-14 ; C_M1_SUB
C$113 COM COM 2.87761104052e-15 ; C_M1_SUB
C$114 COM COM 2.87761104052e-15 ; C_M1_SUB
C$115 \\x20P2_8 COM 2.87761104052e-15 ; C_M1_SUB
C$116 \\x20P2_4 COM 2.87761104052e-15 ; C_M1_SUB
C$117 \\x20P2_8 COM 2.87761104052e-15 ; C_M1_SUB
C$118 \\x20P2_2 COM 2.87761104052e-15 ; C_M1_SUB
C$119 \\x20P1 COM 2.87761104052e-15 ; C_M1_SUB
C$120 \\x20P2_8 COM 2.87761104052e-15 ; C_M1_SUB
C$121 \\x20P2_4 COM 2.87761104052e-15 ; C_M1_SUB
C$122 \\x20P2_8 COM 2.87761104052e-15 ; C_M1_SUB
C$123 COM COM 4.31641656079e-15 ; C_M1_SUB
C$124 COM COM 4.31641656079e-15 ; C_M1_SUB
C$125 COM COM 8.63283312158e-15 ; C_M1_SUB
C$126 COM COM 1.87044717634e-14 ; C_M1_SUB
C$127 COM COM 1.87044717634e-14 ; C_M1_SUB
C$128 COM COM 1.87044717634e-14 ; C_M1_SUB
C$129 COM COM 1.87044717634e-14 ; C_M1_SUB
C$130 COM COM 1.87044717634e-14 ; C_M1_SUB
C$131 COM COM 8.63283312158e-15 ; C_M1_SUB
C$132 \\x20P1 COM 2.25567575112e-14 ; C_M2_SUB
C$133 \\x20P1 COM 2.50630639013e-15 ; C_M2_SUB
C$134 \\x20P1 COM 7.5189191704e-15 ; C_M2_SUB
C$135 \\x20P1 COM 2.50630639013e-15 ; C_M2_SUB
C$136 \\x20P1 COM 8.35435463378e-15 ; C_M2_SUB
C$137 \\x20P1 COM 2.50630639013e-15 ; C_M2_SUB
C$138 \\x20P1 COM 1.33669674141e-14 ; C_M2_SUB
C$139 \\x20P1 COM 8.35435463378e-15 ; C_M2_SUB
C$140 \\x20P1 COM 2.50630639013e-15 ; C_M2_SUB
C$141 \\x20P1 COM 7.5189191704e-15 ; C_M2_SUB
C$142 \\x20P1 COM 2.50630639013e-15 ; C_M2_SUB
C$143 \\x20P1 COM 8.35435463378e-15 ; C_M2_SUB
C$144 \\x20P1 COM 2.50630639013e-15 ; C_M2_SUB
C$145 \\x20P1 COM 7.5189191704e-15 ; C_M2_SUB
C$146 \\x20P1 COM 2.50630639013e-15 ; C_M2_SUB
C$147 \\x20P1 COM 2.25567575112e-14 ; C_M2_SUB
C$148 \\x20P2_2 COM 2.25567575112e-14 ; C_M2_SUB
C$149 \\x20P2_2 COM 2.50630639013e-15 ; C_M2_SUB
C$150 \\x20P2_2 COM 7.5189191704e-15 ; C_M2_SUB
C$151 \\x20P2_2 COM 2.50630639013e-15 ; C_M2_SUB
C$152 \\x20P2_2 COM 8.35435463378e-15 ; C_M2_SUB
C$153 \\x20P2_2 COM 2.50630639013e-15 ; C_M2_SUB
C$154 \\x20P2_2 COM 7.5189191704e-15 ; C_M2_SUB
C$155 \\x20P2_2 COM 2.50630639013e-15 ; C_M2_SUB
C$156 \\x20P2_2 COM 8.35435463378e-15 ; C_M2_SUB
C$157 \\x20P2_2 COM 2.50630639013e-15 ; C_M2_SUB
C$158 \\x20P2_2 COM 7.5189191704e-15 ; C_M2_SUB
C$159 \\x20P2_2 COM 2.50630639013e-15 ; C_M2_SUB
C$160 \\x20P2_2 COM 8.35435463378e-15 ; C_M2_SUB
C$161 \\x20P2_2 COM 2.50630639013e-15 ; C_M2_SUB
C$162 \\x20P2_2 COM 7.5189191704e-15 ; C_M2_SUB
C$163 \\x20P2_2 COM 2.50630639013e-15 ; C_M2_SUB
C$164 \\x20P2_2 COM 2.25567575112e-14 ; C_M2_SUB
C$165 \\x20P2_4 COM 2.25567575112e-14 ; C_M2_SUB
C$166 \\x20P2_4 COM 2.50630639013e-15 ; C_M2_SUB
C$167 \\x20P2_4 COM 7.5189191704e-15 ; C_M2_SUB
C$168 \\x20P2_4 COM 2.50630639013e-15 ; C_M2_SUB
C$169 \\x20P2_4 COM 8.35435463378e-15 ; C_M2_SUB
C$170 \\x20P2_4 COM 2.50630639013e-15 ; C_M2_SUB
C$171 \\x20P2_4 COM 7.5189191704e-15 ; C_M2_SUB
C$172 \\x20P2_4 COM 2.50630639013e-15 ; C_M2_SUB
C$173 \\x20P2_4 COM 8.35435463378e-15 ; C_M2_SUB
C$174 \\x20P2_4 COM 1.33669674141e-14 ; C_M2_SUB
C$175 \\x20P2_4 COM 2.50630639013e-15 ; C_M2_SUB
C$176 \\x20P2_4 COM 8.35435463378e-15 ; C_M2_SUB
C$177 \\x20P2_4 COM 2.50630639013e-15 ; C_M2_SUB
C$178 \\x20P2_4 COM 7.5189191704e-15 ; C_M2_SUB
C$179 \\x20P2_4 COM 2.50630639013e-15 ; C_M2_SUB
C$180 \\x20P2_4 COM 2.25567575112e-14 ; C_M2_SUB
C$181 \\x20P2_8 COM 2.25567575112e-14 ; C_M2_SUB
C$182 \\x20P2_8 COM 2.50630639013e-15 ; C_M2_SUB
C$183 \\x20P2_8 COM 7.5189191704e-15 ; C_M2_SUB
C$184 \\x20P2_8 COM 2.50630639013e-15 ; C_M2_SUB
C$185 \\x20P2_8 COM 8.35435463378e-15 ; C_M2_SUB
C$186 \\x20P2_8 COM 2.50630639013e-15 ; C_M2_SUB
C$187 \\x20P2_8 COM 7.5189191704e-15 ; C_M2_SUB
C$188 \\x20P2_8 COM 2.50630639013e-15 ; C_M2_SUB
C$189 \\x20P2_8 COM 8.35435463378e-15 ; C_M2_SUB
C$190 \\x20P2_8 COM 1.33669674141e-14 ; C_M2_SUB
C$191 \\x20P2_8 COM 2.50630639013e-15 ; C_M2_SUB
C$192 \\x20P2_8 COM 8.35435463378e-15 ; C_M2_SUB
C$193 \\x20P2_8 COM 2.50630639013e-15 ; C_M2_SUB
C$194 \\x20P2_8 COM 7.5189191704e-15 ; C_M2_SUB
C$195 \\x20P2_8 COM 2.50630639013e-15 ; C_M2_SUB
C$196 \\x20P2_8 COM 2.25567575112e-14 ; C_M2_SUB
C$197 COM COM 2.80567076451e-14 ; C_PO_SUB
C$198 \\x20P1 COM 8.63283312158e-15 ; C_PO_SUB
C$199 \\x20P1 COM 8.63283312158e-15 ; C_PO_SUB
C$200 \\x20P1 COM 8.63283312158e-15 ; C_PO_SUB
C$201 COM COM 3.02149159255e-14 ; C_PO_SUB
C$202 \\x20P1 COM 8.63283312158e-15 ; C_PO_SUB
C$203 \\x20P1 COM 8.63283312158e-15 ; C_PO_SUB
C$204 \\x20P1 COM 8.63283312158e-15 ; C_PO_SUB
C$205 \\x20P1 COM 8.63283312158e-15 ; C_PO_SUB
C$206 COM COM 2.80567076451e-14 ; C_PO_SUB
C$207 COM COM 8.63283312158e-15 ; C_PO_SUB
C$208 COM COM 1.0791041402e-14 ; C_PO_SUB
C$209 COM COM 1.0791041402e-14 ; C_PO_SUB
C$210 \\x20P1 COM 1.51074579628e-14 ; C_PO_SUB
C$211 \\x20P1 COM 1.51074579628e-14 ; C_PO_SUB
C$212 \\x20P1 COM 1.51074579628e-14 ; C_PO_SUB
C$213 \\x20P1 COM 1.51074579628e-14 ; C_PO_SUB
C$214 \\x20P1 COM 1.51074579628e-14 ; C_PO_SUB
C$215 \\x20P1 COM 1.51074579628e-14 ; C_PO_SUB
C$216 \\x20P1 COM 1.51074579628e-14 ; C_PO_SUB
C$217 COM COM 1.0791041402e-14 ; C_PO_SUB
C$218 \\x20P1 COM 1.51074579628e-14 ; C_PO_SUB
C$219 \\x20P1 COM 1.51074579628e-14 ; C_PO_SUB
C$220 \\x20P1 COM 1.51074579628e-14 ; C_PO_SUB
C$221 \\x20P1 COM 1.51074579628e-14 ; C_PO_SUB
C$222 \\x20P1 COM 1.51074579628e-14 ; C_PO_SUB
C$223 \\x20P1 COM 1.51074579628e-14 ; C_PO_SUB
C$224 \\x20P1 COM 1.51074579628e-14 ; C_PO_SUB
C$225 \\x20P1 COM 1.51074579628e-14 ; C_PO_SUB
C$226 COM COM 1.0791041402e-14 ; C_PO_SUB
C$227 \\x20P1 COM 8.63283312158e-15 ; C_PO_SUB
C$228 \\x20P1 COM 8.63283312158e-15 ; C_PO_SUB
C$229 \\x20P1 COM 8.63283312158e-15 ; C_PO_SUB
C$230 \\x20P1 COM 8.63283312158e-15 ; C_PO_SUB
C$231 \\x20P1 COM 8.63283312158e-15 ; C_PO_SUB
C$232 \\x20P1 COM 8.63283312158e-15 ; C_PO_SUB
C$233 \\x20P1 COM 8.63283312158e-15 ; C_PO_SUB
C$234 \\x20P1 COM 8.63283312158e-15 ; C_PO_SUB
C$235 COM COM 2.80567076451e-14 ; C_PO_SUB
C$236 COM COM 2.80567076451e-14 ; C_PO_SUB
.ENDS Cmirror_1aN

.SUBCKT GuardRing$1 \$1 \$2
.ENDS GuardRing$1
